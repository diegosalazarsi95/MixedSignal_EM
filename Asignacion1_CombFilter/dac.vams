/////////////////////////////////////////
// N-bit DAC from VerligoAMS_Designers
// Ing. Diego Salazar
//
/////////////////////////////////////////

`include "disciplines.vams"
`timescale 1ps / 1ps

module dac(out, in, clk);
	parameter integer bits = 8 from [1:24];   // resolution (bits)
    	parameter real fullscale = 1.0;           // output range is from 0 to fullscale (V)
    	parameter real tt = 0;                    // output transition time
    	output out;
    	electrical out;
    	input [bits-1:0] in;
    	input clk;
    	logic in, clk;

    	real r_out;
    	integer weight;
    	integer i;

    	always @(posedge clk) begin
        	r_out=0.0;
        	weight = 2;
        	for (i=bits-1; i>=0; i=i-1) begin
            		if (in[i]) r_out = r_out + fullscale / weight;
            		weight = weight * 2;
        	end  // End for
    	end  // End always

    	analog V(out) <+ transition(r_out,0,tt,tt);
endmodule
